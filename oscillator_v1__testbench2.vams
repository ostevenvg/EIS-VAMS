/*============================================================
  Filename:      oscillator_v1__testbench2.vams
  Created On:    2016-04-17 21:34:25
  Last Modified: 2016-11-15 21:28:29
  Author:        Oscar Villalta G.
  Project:       Impedance spectroscopy architecture modeling
  Institution:   TEC-Costa Rica

  Description:
============================================================*/

`include "disciplines.h"
`include "constants.h"
`timescale 1ns/1ps

module testbench2 (
	output voltage vsin, vsquare,
	output wreal freq_out, Csensor
);

	//Sin generator parameters
	real freq, cap, ampl=1, offset=0;
	integer k;

	//assign value to output
    assign freq_out = freq;
    assign Csensor = cap;
    initial begin

	//Capacitance swept
    /*	freq = 125e6;
    	cap  = 0.55e-12;
    	//#5000
		for (k=1; k<=20; k=k+1) begin
			#100000 cap = 0.6e-12 + 0.2e-12*k;
		end
	*/
	//Frequency swept
    	freq = 10e6;
    	cap  = 18e-12;
		for (k=2; k<=25; k=k+1) begin
			#100000 freq =  freq + 15e6;
		end
	end

	analog begin
		V(vsin) <+ ampl*sin(2.0*`M_PI*freq*$abstime) + offset;
		if(V(vsin)>0) V(vsquare) <+ ampl;
		else V(vsquare) <+ -ampl;
	end

endmodule
