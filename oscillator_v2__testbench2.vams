/*============================================================
  Filename:      oscillator_v2__testbench2.vams
  Created On:    2016-04-17 21:34:25
  Last Modified: 2017-01-30 09:31:47
  Author:        Oscar Villalta G.
  Project:       Impedance spectroscopy architecture modeling
  Institution:   TEC-Costa Rica

  Description:
============================================================*/

`include "disciplines.h"
`include "constants.h"
`timescale 1ns/1ps

module testbench2 (
	output voltage vsin, vsquare,
	output wreal freq_out, Csensor
);

	//Sin generator parameters
	real freq, cap, ampl=1, offset=0;
	integer k;

	//assign value to output
    assign freq_out = freq;
    assign Csensor = cap;
    initial begin

	//Capacitance swept
    	freq = 150e6;
    	cap  = 0.1e-12;
    	#10000
		for (k=2; k<=20; k=k+1) begin
			#10000 cap = 0.1e-12 + 0.4e-12*k;
		end

	/*
	//Frequency swept
    	freq = 10e6;
    	cap  = 18e-12;
    	#40000 freq = 10e6;
		#40000 freq = 20e6;
		#40000 freq = 30e6;
		#40000 freq = 50e6;
		#50000 freq = 75e6;
		#60000 freq = 100e6;
		#80000 freq = 150e6;
		#90000 freq = 200e6;
		#150000 freq = 300e6;
		#150000 freq = 350e6;
		#150000 freq = 500e6;
	*/
	end

	analog begin
		V(vsin) <+ ampl*sin(2.0*`M_PI*freq*$abstime) + offset;
		if(V(vsin)>0) V(vsquare) <+ ampl;
		else V(vsquare) <+ -ampl;
	end

endmodule
