/*============================================================
  Filename:      sensor.vams
  Created On:    2016-04-17 22:29:07
  Last Modified: 2016-08-29 22:30:28
  Author:        Oscar Villalta G.
  Project:       Impedance spectroscopy architecture modeling
  Institution:   TEC-Costa Rica

  Description:
============================================================*/

`include "disciplines.h"
`include "constants.h"

module sensor (
	inout electrical load
);

  parameter real C=1e-12, R=13.5e3;

  analog begin
  		I(load) <+ C * ddt(V(load)) + V(load)/R;
  end

endmodule
