/*============================================================
  Filename:      oscillator_ALL__ALL.vams
  Created On:    2016-08-03 23:35:43
  Last Modified: 2016-11-06 23:14:24
  Author:        Oscar Villalta G.
  Project:       Impedance spectroscopy architecture modeling
  Institution:   TEC-Costa Rica

  Description:
============================================================*/

`include "disciplines.h"
`include "constants.h"

module peak_detector (
	input voltage in,
	output voltage peak
);

	parameter real tau = 1u;
	real v_peak = 0, v_peak0 = 0, t_peak0=0, gain_peak=0.9;

    analog begin
    	if (V(in)>v_peak) begin
    		v_peak = V(in);
    		v_peak0 = v_peak;
    		t_peak0 = $abstime;
    	end
    	else  begin
    		v_peak = v_peak0 * `M_PI ** ((t_peak0 - $abstime) / tau);
    	end
    	V(peak) <+ gain_peak*v_peak;
    end

endmodule

module ALL (
	input voltage in_sen,
	input voltage in_ref,
	output voltage vall
);

	real amp_gain = 1000, vdd = 1.5, v_vall;
	voltage v_peak_sen, v_peak_ref;

	peak_detector peak_sen (.in(in_sen), .peak(v_peak_sen));
    peak_detector peak_ref (.in(in_ref), .peak(v_peak_ref));

    analog begin
    	v_vall = amp_gain * (V(v_peak_sen)-V(v_peak_ref));
    	//Saturation values
    	if (v_vall<0.001) v_vall = 0.001;
    	if (v_vall>vdd) v_vall = vdd;
    	V(vall) <+ slew(v_vall,1e6);
    end

endmodule
