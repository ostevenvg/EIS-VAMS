/*============================================================
  Filename:      logic_comparator.vams
  Created On:    2016-08-22 19:58:48
  Last Modified: 2016-08-22 20:00:39
  Author:        Oscar Villalta G.
  Project:       Impedance spectroscopy architecture modeling
  Institution:   TEC-Costa Rica

  Description:
============================================================*/

`include "disciplines.h"
`include "constants.h"

module logic_comparator (
	input [6:0] in1,
	input [6:0] in2,
	output out
);

   assign out = in1 == in2 ? 1'b1 : 1'b0;

endmodule
