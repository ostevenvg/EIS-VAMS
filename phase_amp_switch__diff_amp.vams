/*============================================================
  Filename:      phase_amp_switch__diff_amp.vams
  Created On:    2016-08-16 22:18:47
  Last Modified: 2017-01-20 15:55:51
  Author:        Oscar Villalta G.
  Project:       Impedance spectroscopy architecture modeling
  Institution:   TEC-Costa Rica

  Description:
============================================================*/

`include "disciplines.h"
`include "constants.h"

module diff_amp (
	input voltage in_pos,
	input voltage in_neg,
	output voltage out_pos,
	output voltage out_neg
);

	parameter gain = 1e4;

    analog begin
    	V(out_pos) <+   gain * (V(in_pos) - V(in_neg))/2;
    	V(out_neg) <+  -gain * (V(in_pos) - V(in_neg))/2;
    end

endmodule
