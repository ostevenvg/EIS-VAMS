/*============================================================
  Filename:      lock_in_v1__testbench2.vams
  Created On:    2016-04-17 21:34:25
  Last Modified: 2017-04-02 11:02:22
  Author:        Oscar Villalta G.
  Project:       Impedance spectroscopy architecture modeling
  Institution:   TEC-Costa Rica

  Description:
============================================================*/

`include "disciplines.h"
`include "constants.h"
`timescale 1ns/1ps

module testbench2 (
	output voltage vsin, vcos,
	output wreal freq_out, C_out, R_out
);

	//Sin generator parameters
	real freq, Cap, Res, ampl=1, offset=0;
	integer k;

	//assign value to output
    assign freq_out = freq;
    assign C_out    = Cap;
    assign R_out   = Res;

    //initial conditions
    initial begin
    	freq = 1e6;
    	Cap  = 7.8e-12;
    	Res  = 1e3;
    end

	analog begin
		V(vsin) <+ ampl*sin(2.0*`M_PI*freq*$abstime) + offset;
		V(vcos) <+ ampl*cos(2.0*`M_PI*freq*$abstime) + offset;
	end

	initial begin
		//Frequency swept
		for (k=2; k<=10; k=k+1) begin
			#5000 freq =  k * 1e6;
		end
		for (k=2; k<=10; k=k+1) begin
			#5000 freq =  k * 10e6;
		end

		#500
		//freq = 100e6;
		Cap  = 7.8e-12;

		//Capacitance swept
		for (k=2; k<=1e5; k=k+10) begin
			#4000 Cap = 1e-9/k;
		end
	end

endmodule
