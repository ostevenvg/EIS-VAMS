/*============================================================
  Filename:      synchronous_sampling_v0__sensor.vams
  Created On:    2016-04-17 22:29:07
  Last Modified: 2017-01-19 10:47:38
  Author:        Oscar Villalta G.
  Project:       Impedance spectroscopy architecture modeling
  Institution:   TEC-Costa Rica

  Description:
============================================================*/

`include "disciplines.h"
`include "constants.h"

module sensor (
	inout electrical load
);

  parameter real C=1e-12, R=10e3;

  analog begin
      //Parallel
      //I(load) <+ C * ddt(V(load)) + V(load)/R;
      //Series
      V(load) <+ R*I(load) + (1/C)*idt(I(load));
  end

endmodule
