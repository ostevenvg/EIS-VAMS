/*============================================================
  Filename:      phase_amp_switch__VCCS.vams
  Created On:    2016-08-15 20:54:53
  Last Modified: 2017-01-20 15:56:21
  Author:        Oscar Villalta G.
  Project:       Impedance spectroscopy architecture modeling
  Institution:   TEC-Costa Rica

  Description:
============================================================*/

`include "disciplines.h"
`include "constants.h"

module VCCS (
	input voltage in_neg,
	input voltage in_pos,
	output current out_neg,
	output current out_pos
);

	parameter gain = 1e-6;

    analog begin
    	I(out_pos) <+   gain * (V(in_pos) - V(in_neg))/2;
    	I(out_neg) <+  -gain * (V(in_pos) - V(in_neg))/2;
    end

endmodule
