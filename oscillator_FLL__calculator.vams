/*============================================================
  Filename:      oscillator_FLL__calculator.vams
  Created On:    2017-01-17 19:40:13
  Last Modified: 2017-01-17 22:03:45
  Author:        Oscar Villalta G.
  Project:       Impedance spectroscopy architecture modeling
  Institution:   TEC-Costa Rica

  Description:
============================================================*/

`include "disciplines.h"
`include "constants.h"
`timescale 1ns/1ns

module calculator (
	input wreal fref,
	input [6:0] count,
	output wreal Csensor
);

assign  Csensor = Cs;
real Cs, fosc;

//Oscillator parameters
real Rref= 2.1e4;
real Cref= 1e-12;
real Gain=35;

analog begin
	fosc = fref * count *2;

end

always  begin
	#10
	if(fosc>0) Cs = (Gain/(Rref*fosc*2.0*`M_PI)) - Cref;
	else Cs = 0;
end

endmodule
