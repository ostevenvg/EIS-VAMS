/*============================================================
  Filename:      counter.vams
  Created On:    2016-08-08 23:52:09
  Last Modified: 2017-01-16 21:13:52
  Author:        Oscar Villalta G.
  Project:       Impedance spectroscopy architecture modeling
  Institution:   TEC-Costa Rica

  Description:
============================================================*/

`include "disciplines.h"
`include "constants.h"

module counter (
	input  clk,
	input  rst,
	input  en,
	output reg [31:0] out
);

	initial begin
		out = 0;
	end

	always @(posedge clk) begin
		if (rst) begin
			out <= 0;
		end
		else if (en) begin
			out <= out + 1;
		end
	end

endmodule
