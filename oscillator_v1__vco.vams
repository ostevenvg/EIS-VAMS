/*============================================================
  Filename:      oscillator_v1__vco.vams
  Created On:    2016-04-26 21:58:39
  Last Modified: 2016-10-31 21:12:28
  Author:        Oscar Villalta G.
  Project:       Impedance spectroscopy architecture modeling
  Institution:   TEC-Costa Rica

  Description:
============================================================*/

`include "disciplines.h"
`include "constants.h"

module vco (
	input voltage in,
	output voltage out
);

	parameter real fnom=500e6, gain=200e6, amp=1;
	parameter real Csensor=5e-12;
  real phase, fvco;

    analog begin
    	fvco = 1e-12*fnom/Csensor+gain*V(in);
    	if(fvco<0) fvco = 0;
    	phase = idtmod(fvco, 0, 1, 0);
    	//V(out) <+ amp*sin(2*`M_PI*phase);
    	//square generator
    	if(phase>0.5) V(out) <+ amp;
    	else V(out) <+ -amp;
    end

endmodule
