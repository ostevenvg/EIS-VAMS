/*============================================================
  Filename:      synchronous_sampling_v0__calculator.vams
  Created On:    2017-01-19 10:58:24
  Last Modified: 2017-01-19 15:30:32
  Author:        Oscar Villalta G.
  Project:       Impedance spectroscopy architecture modeling
  Institution:   TEC-Costa Rica

  Description:
============================================================*/

`include "disciplines.h"
`include "constants.h"
`timescale 100ps/1ps

module calculator (
	input zero,
	input peak,
	input voltage vsh,
	input wreal fref,
	output wreal Csensor,
	output wreal Rsensor
);

assign Csensor = Csx;
assign Rsensor = Rsx;

//External components variables
real input_amp = 1;
real Av2i = 1000;

real Cs=0, Rs=0, vzero=0, vpeak=0, Zphase_rad=0, Zamp=0;
real Csx, Rsx;

analog begin
	//Measusre cycle: peak -> zero
	@( negedge(peak) ) begin
		vpeak = V(vsh);
	end

	@( negedge(zero) ) begin
		vzero = V(vsh);
		if (vpeak != 0) begin
			Zphase_rad = atan(vzero/vpeak);
			Zamp = Av2i/abs(vzero / sin(Zphase_rad));

			//Parallel R/C configuration
			//Rs = Zamp * cos(Zphase_rad)*(1+tan(Zphase_rad)*tan(Zphase_rad));
			//Cs = -tan(Zphase_rad) / (2*`M_PI*fref*Rs);

			//Series R/C configuration
			Rs = Zamp * cos(Zphase_rad);
			Cs = -1 / (2*`M_PI*fref*Zamp*sin(Zphase_rad));
		end
	end

end

//Update wreal outputs
always begin
	#1
	Csx = Cs;
	Rsx = Rs;
end

endmodule
